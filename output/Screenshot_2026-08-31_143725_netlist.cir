* Extracted from Screenshot_2026-08-31_143725.png
* Generated by Project NETLIST
Q1 NET1 UNCONNECTED_Q1.C NET1 1
U1 UNCONNECTED_U1.T1 UNCONNECTED_U1.T2 1
U10 UNCONNECTED_U10.T1 NET2 1
U11 NET2 NET2 1
U12 NET3 NET4 1
U13 NET5 UNCONNECTED_U13.T2 1
U14 NET6 NET6 1
U15 NET7 NET7 1
U16 NET2 NET2 1
U17 NET2 NET2 1
U18 NET2 NET2 1
U19 UNCONNECTED_U19.T1 UNCONNECTED_U19.T2 1
U2 UNCONNECTED_U2.T1 UNCONNECTED_U2.T2 1
U20 NET8 NET9 1
U21 NET10 NET10 1
U22 NET10 NET10 1
U23 NET9 NET9 1
U24 NET11 UNCONNECTED_U24.T2 1
U25 NET12 NET13 1
U26 NET14 NET14 1
U27 NET15 NET15 1
U28 NET14 NET16 1
U29 NET17 NET18 1
U3 NET19 NET19 1
U30 NET20 UNCONNECTED_U30.T2 1
U31 UNCONNECTED_U31.T1 NET15 1
U32 NET21 NET21 1
U33 NET22 NET23 1
U34 NET24 NET25 1
U35 NET26 UNCONNECTED_U35.T2 1
U36 NET27 NET27 1
U4 NET28 NET28 1
U5 NET29 NET29 1
U6 NET30 NET30 1
U7 NET31 NET31 1
U8 NET32 UNCONNECTED_U8.T2 1
U9 NET33 NET2 1
.end
