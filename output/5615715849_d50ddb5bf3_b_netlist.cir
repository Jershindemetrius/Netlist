* Extracted from 5615715849_d50ddb5bf3_b.jpg
* Generated by Project NETLIST
C1 NET1 NET1 1
C10 NET2 NET2 1
C11 UNCONNECTED_C11.NEG UNCONNECTED_C11.POS 1
C12 NET1 NET1 1
C13 NET1 NET1 1
C14 NET1 NET1 1
C15 NET1 NET1 1
C16 NET1 NET1 1
C2 NET3 NET3 1
C3 UNCONNECTED_C3.T1 NET1 1
C4 NET4 NET5 1
C5 UNCONNECTED_C5.T1 NET4 1
C6 NET1 NET1 1
C7 UNCONNECTED_C7.T1 UNCONNECTED_C7.T2 1
C8 UNCONNECTED_C8.T1 UNCONNECTED_C8.T2 1
C9 UNCONNECTED_C9.T1 UNCONNECTED_C9.T2 1
D1 NET6 NET6 1
D2 NET1 NET1 1
D3 NET7 UNCONNECTED_D3.K 1
D4 NET8 NET8 1
D5 NET1 NET1 1
D6 NET9 NET9 1
D7 UNCONNECTED_D7.A UNCONNECTED_D7.K 1
D8 NET1 NET1 1
D9 NET10 NET1 1
GND1 0 1
GND10 0 1
GND11 0 1
GND2 0 1
GND3 0 1
GND4 0 1
GND5 0 1
GND6 0 1
GND7 0 1
GND8 0 1
GND9 0 1
L1 UNCONNECTED_L1.T1 UNCONNECTED_L1.T2 1
Q1 UNCONNECTED_Q1.B NET11 UNCONNECTED_Q1.E 1
Q2 NET12 UNCONNECTED_Q2.C NET1 1
Q3 UNCONNECTED_Q3.B NET1 UNCONNECTED_Q3.E 1
Q4 NET13 NET14 UNCONNECTED_Q4.E 1
R1 NET8 NET8 1
R10 NET1 NET1 1
R11 NET4 NET4 1
R12 NET4 UNCONNECTED_R12.T2 1
R13 NET8 NET1 1
R14 NET1 NET1 1
R15 NET15 NET16 1
R16 NET1 NET1 1
R17 NET13 NET17 1
R18 NET13 NET13 1
R2 NET18 NET1 1
R3 UNCONNECTED_R3.T1 UNCONNECTED_R3.T2 1
R4 NET19 NET5 1
R5 NET1 NET1 1
R6 NET20 NET5 1
R7 NET5 NET5 1
R8 NET4 NET4 1
R9 NET1 NET8 1
T1 UNCONNECTED_T1.P1 UNCONNECTED_T1.P2 UNCONNECTED_T1.S1 UNCONNECTED_T1.S2 1
U1 UNCONNECTED_U1.T1 UNCONNECTED_U1.T2 1
U10 NET21 NET22 1
U100 NET23 UNCONNECTED_U100.T2 1
U101 NET16 UNCONNECTED_U101.T2 1
U102 NET16 NET16 1
U103 UNCONNECTED_U103.T1 UNCONNECTED_U103.T2 1
U104 UNCONNECTED_U104.T1 UNCONNECTED_U104.T2 1
U105 UNCONNECTED_U105.T1 UNCONNECTED_U105.T2 1
U106 NET15 NET15 1
U107 UNCONNECTED_U107.T1 UNCONNECTED_U107.T2 1
U108 NET15 UNCONNECTED_U108.T2 1
U109 NET1 NET1 1
U11 UNCONNECTED_U11.T1 UNCONNECTED_U11.T2 1
U110 NET24 NET25 1
U111 NET26 UNCONNECTED_U111.T2 1
U112 NET27 NET28 1
U113 NET29 NET30 1
U114 NET1 NET1 NET1 1
U115 NET1 NET1 1
U116 NET1 UNCONNECTED_U116.G NET1 1
U117 NET1 NET1 1
U118 NET1 NET1 1
U119 NET1 NET1 1
U12 NET18 NET18 1
U120 NET1 NET1 1
U121 NET1 NET1 1
U122 UNCONNECTED_U122.T1 UNCONNECTED_U122.T2 1
U123 UNCONNECTED_U123.T1 UNCONNECTED_U123.T2 1
U124 NET31 NET1 1
U125 NET32 NET33 1
U126 UNCONNECTED_U126.T1 UNCONNECTED_U126.T2 1
U127 NET34 NET1 1
U128 NET35 NET36 1
U129 NET37 NET1 1
U13 UNCONNECTED_U13.T1 UNCONNECTED_U13.T2 1
U130 NET31 UNCONNECTED_U130.T2 1
U131 NET38 NET31 1
U132 NET1 NET1 1
U133 NET1 UNCONNECTED_U133.T2 1
U134 NET39 NET1 1
U135 UNCONNECTED_U135.T1 NET1 1
U136 NET39 NET40 1
U137 NET1 NET1 1
U138 NET1 NET1 1
U139 NET1 NET1 1
U14 NET18 UNCONNECTED_U14.T2 1
U140 UNCONNECTED_U140.T1 UNCONNECTED_U140.T2 1
U141 UNCONNECTED_U141.T1 UNCONNECTED_U141.T2 1
U142 NET41 NET1 1
U143 NET42 NET13 1
U144 NET1 NET1 1
U145 UNCONNECTED_U145.T1 NET13 1
U146 NET13 UNCONNECTED_U146.T2 1
U147 UNCONNECTED_U147.T1 UNCONNECTED_U147.T2 1
U148 UNCONNECTED_U148.T1 UNCONNECTED_U148.T2 1
U149 UNCONNECTED_U149.T1 UNCONNECTED_U149.T2 1
U15 NET43 NET44 1
U150 NET13 NET13 1
U151 NET13 NET13 1
U152 UNCONNECTED_U152.T1 UNCONNECTED_U152.T2 1
U153 NET45 UNCONNECTED_U153.T2 1
U154 UNCONNECTED_U154.T1 UNCONNECTED_U154.T2 1
U155 UNCONNECTED_U155.T1 UNCONNECTED_U155.T2 1
U156 UNCONNECTED_U156.T1 NET45 1
U157 UNCONNECTED_U157.T1 UNCONNECTED_U157.T2 1
U158 UNCONNECTED_U158.T1 NET46 1
U159 NET17 NET1 1
U16 NET8 NET8 1
U160 UNCONNECTED_U160.T1 UNCONNECTED_U160.T2 1
U161 NET13 UNCONNECTED_U161.T2 1
U162 NET47 NET13 1
U17 NET1 NET1 1
U18 NET48 NET49 1
U19 UNCONNECTED_U19.T1 UNCONNECTED_U19.T2 1
U2 UNCONNECTED_U2.T1 UNCONNECTED_U2.T2 1
U20 NET8 NET8 1
U21 NET1 NET1 1
U22 UNCONNECTED_U22.T1 NET1 1
U23 NET1 NET1 1
U24 NET50 NET51 1
U25 NET3 NET52 1
U26 NET53 NET54 1
U27 UNCONNECTED_U27.T1 NET19 1
U28 UNCONNECTED_U28.T1 NET19 1
U29 NET5 NET19 1
U3 UNCONNECTED_U3.T1 UNCONNECTED_U3.T2 1
U30 NET55 NET56 1
U31 NET57 NET57 1
U32 UNCONNECTED_U32.T1 UNCONNECTED_U32.T2 1
U33 NET8 NET8 1
U34 UNCONNECTED_U34.T1 UNCONNECTED_U34.T2 1
U35 NET58 NET59 1
U36 UNCONNECTED_U36.T1 UNCONNECTED_U36.T2 1
U37 NET5 NET5 1
U38 NET4 NET4 1
U39 NET60 NET60 1
U4 UNCONNECTED_U4.T1 NET61 1
U40 NET7 NET7 1
U41 UNCONNECTED_U41.T1 UNCONNECTED_U41.T2 1
U42 NET62 NET63 1
U43 UNCONNECTED_U43.T1 NET64 1
U44 NET1 NET1 1
U45 NET20 NET20 1
U46 NET7 NET7 1
U47 UNCONNECTED_U47.T1 UNCONNECTED_U47.T2 1
U48 NET63 UNCONNECTED_U48.T2 1
U49 NET1 NET1 1
U5 NET65 NET66 1
U50 NET1 NET1 1
U51 NET3 UNCONNECTED_U51.T2 1
U52 NET3 NET3 1
U53 NET3 UNCONNECTED_U53.T2 1
U54 UNCONNECTED_U54.T1 UNCONNECTED_U54.T2 1
U55 UNCONNECTED_U55.T1 NET64 1
U56 NET64 UNCONNECTED_U56.T2 1
U57 NET5 NET5 1
U58 NET67 NET67 1
U59 NET7 UNCONNECTED_U59.T2 1
U6 NET11 NET68 1
U60 UNCONNECTED_U60.T1 UNCONNECTED_U60.T2 1
U61 NET8 NET8 1
U62 UNCONNECTED_U62.T1 NET8 1
U63 NET8 NET8 1
U64 NET69 UNCONNECTED_U64.T2 1
U65 UNCONNECTED_U65.T1 UNCONNECTED_U65.T2 1
U66 NET1 UNCONNECTED_U66.T2 1
U67 NET1 NET1 1
U68 NET70 NET70 1
U69 NET1 NET1 1
U7 NET1 NET6 1
U70 NET71 NET1 1
U71 NET4 UNCONNECTED_U71.T2 1
U72 NET4 NET4 1
U73 UNCONNECTED_U73.T1 NET8 1
U74 NET8 NET8 1
U75 UNCONNECTED_U75.T1 UNCONNECTED_U75.T2 1
U76 UNCONNECTED_U76.T1 UNCONNECTED_U76.T2 1
U77 NET72 UNCONNECTED_U77.T2 1
U78 NET2 NET73 1
U79 NET1 NET74 1
U8 NET1 NET1 1
U80 NET1 NET75 1
U81 NET76 NET1 1
U82 NET2 NET77 1
U83 UNCONNECTED_U83.T1 UNCONNECTED_U83.T2 1
U84 NET78 NET78 1
U85 NET79 NET80 1
U86 UNCONNECTED_U86.T1 NET81 1
U87 NET16 NET1 1
U88 NET82 NET1 1
U89 NET82 NET82 1
U9 UNCONNECTED_U9.T1 UNCONNECTED_U9.T2 1
U90 UNCONNECTED_U90.T1 NET80 1
U91 NET81 UNCONNECTED_U91.T2 1
U92 UNCONNECTED_U92.T1 UNCONNECTED_U92.T2 1
U93 NET1 NET1 1
U94 UNCONNECTED_U94.T1 UNCONNECTED_U94.T2 1
U95 NET16 UNCONNECTED_U95.IN_NONINV UNCONNECTED_U95.OUT UNCONNECTED_U95.V_NEG UNCONNECTED_U95.V_POS 1
U96 UNCONNECTED_U96.T1 NET7 1
U97 UNCONNECTED_U97.T1 UNCONNECTED_U97.T2 1
U98 NET1 NET1 1
U99 NET23 NET83 1
V1 NET3 NET18 1
V2 UNCONNECTED_V2.NEG UNCONNECTED_V2.POS 1
V3 NET15 NET3 1
V4 NET1 NET84 1
.end
