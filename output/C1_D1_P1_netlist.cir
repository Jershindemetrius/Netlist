* Extracted from C1_D1_P1.jpg
* Generated by Project NETLIST
.end
